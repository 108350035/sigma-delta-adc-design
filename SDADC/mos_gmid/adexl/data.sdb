ADE simulation setup
Run mode: Single Run, Sweeps and Corners
Tests:
  SDADC:mos_gmid:1: SDADC/mos_gmid/schematic, simulator spectre
    Outputs: nil; (getData("M0:id" ?result "dc") / pv("M0" "w" ?result "instance")); nch18_ft; nch18_Vov; nch18_Vdsat; pch18_Cdd_Cgg; nch18_Cgd_Cgg; pch18_Cgd_Cgg; nch18_id_w; pch18_id_w
Global variables:
  L = {Inclusion List}2u{Inclusion List}{From/To}Linear:0.15u:0.05u:2u{From/To}
  VGS = 0.2 (off)
  vd = 0.2:0.05:0.65
  vg = 0.4
Corners (nominal off):
  model folders: /home/tsmcN28_CLN28HPC/N28/models/spectre
  C0: toplevel.scs[top_tt]
