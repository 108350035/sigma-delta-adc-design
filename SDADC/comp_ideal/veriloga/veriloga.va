`include "discipline.h"
`include "constants.h"

// $Date: 1997/08/28 05:48:45 $
// $Revision: 1.1 $
//
//
// Based on the OVI Verilog-A Language Reference Manual, version 1.0 1996
//
//

//--------------------
// comparator
//
// -  comparator
//
// sigin:	(val,flow)
// sigref:	reference to which 'sigin' is compared (val,flow)
// sigout:	comparator output (val,flow)
//
// INSTANCE parameters
//    sigout_high  = maximum output of the comparator  (val)
//    sigout_low   = minimum output of the comparator  (val)
//    sigin_offset = subtracted from 'sigin' before comparason to sigref (val)
//    comp_slope   = determines the sensitivity of the comparator []
//
// MODEL parameters
//    {none}
//
// Compares ('sigin'-'sigin_offset') to 'sigref' - the output is related to
// their difference by a tanh relationship.
//
// If the difference >>> 'sigref', 'sigout' is 'sigout_high'.
// If the difference = 'sigref', 'sigout' is ('sigout_high' + 'sigout_low')/2.
// If the difference <<< 'sigref', 'sigout' is 'sigout_low'.
// Intermediate points are fitting to a tanh scaled by 'comp_slope'.
//

module comp_ideal(sigin, sigref, sigout);
input sigin, sigref;
output sigout;
electrical sigin, sigref, sigout;
parameter real sigout_high = 10;
parameter real sigout_low = -10;
parameter real sigin_offset = 0;

   analog begin

      @ ( initial_step ) begin
	 if (sigout_high <= sigout_low) begin
	    $display("Range specification error.  sigout_high = (%E) less than sigout_low = (%E).\n", sigout_high, sigout_low );
	    $finish;
	 end
      end

      if(V(sigin,sigref) > 0) V(sigout) <+ sigout_high;
      else V(sigout) <+ sigout_low;
   end
endmodule
