`include "discipline.h"
`include "constants.h"

// $Date: 1997/08/28 05:48:52 $
// $Revision: 1.1 $
//
//
// Based on the OVI Verilog-A Language Reference Manual, version 1.0 1996
//
//

//--------------------
// diffamp
//
// -  differential amplifier (aka opamp)
//
// sigin_p,sigin_n:	(val,flow)
// sigout:		(val,flow)
//
// INSTANCE parameters
//    gain          = amplifier differential gain (val)
//    sigin_offset  = input offset (val)
//
// MODEL parameters
//    {none}
//
// 'sig_out' is 'gain' times the adjusted input differential signal.
// The adjusted input differential signal is the differential input
// minus 'sigin_offset'
//

module diffamp_ideal(Vin,Vip,Vcm,Vop,Von);
input Vin, Vip, Vcm;
output Vop, Von;
electrical Vin, Vip, Vcm, Vop, Von;
parameter real gain = 100000;
parameter real sigin_offset = 0;

   analog begin
      V(Vop) <+   V(Vcm) + (V(Vip, Vin) - sigin_offset) * gain/2;
      V(Von) <+   V(Vcm) - (V(Vip, Vin) - sigin_offset) * gain/2;
    end

endmodule
