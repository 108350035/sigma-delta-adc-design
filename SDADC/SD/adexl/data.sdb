ADE simulation setup
Run mode: Single Run, Sweeps and Corners
Tests:
  SDADC:SDADC:1: SDADC/SDADC/schematic, simulator spectre
Global variables:
  vin = 200m
  fs = 1M
  fin = fs*61/65536
Corners (nominal off):
  model folders: /home/tsmcN28_CLN28HPC/N28/models/spectre
  C0: temperature=27; toplevel.scs[top_tt]
