ADE simulation setup
Run mode: Single Run, Sweeps and Corners
Tests:
  SDADC:diffamp:1: SDADC/diffamp/schematic, simulator spectre
Global variables:
  vin = 0.2
  fs = 1M
  fin = fs
  bias1 = {Inclusion List}0.5{Inclusion List}
  bias2 = 0.75
  bias3 = 0.9
  bias4 = 0.57
  Vn = 0.9
  Vp = 0.9
  Z = 1
Corners (nominal off):
  model folders: /home/tsmcN28_CLN28HPC/N28/models/spectre
  C0: toplevel.scs[top_tt]
